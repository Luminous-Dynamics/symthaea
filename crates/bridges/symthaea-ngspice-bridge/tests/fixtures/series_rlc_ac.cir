* ENG-SPICE-001 deterministic series-RLC AC fixture
* R=10 ohm, L=10 mH, C=1 uF -> f0 ~= 1591.55 Hz, |I|max ~= 0.1 A
V1 in 0 AC 1
R1 in n1 10
L1 n1 n2 10m
C1 n2 0 1u
.ac dec 200 500 5000
.measure ac i_peak MAX mag(i(V1))
.print ac mag(i(V1))
.end
